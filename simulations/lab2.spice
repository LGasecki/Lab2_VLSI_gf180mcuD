** sch_path: /foss/designs/lab_2/lab2.sch
**.subckt lab2
I0 net1 0 I_DAC
E1 net2 0 net1 0 1.0
V1 VDD 0 VDC
*  M1 -  pfet_03v3  IS MISSING !!!!
*  M2 -  pfet_03v3  IS MISSING !!!!
**** begin user architecture code

.include /foss/pdks/gf180mcuD/libs.tech/ngspice/design.ngspice
.lib /foss/pdks/gf180mcuD/libs.tech/ngspice/sm141064.ngspice typical

.param W_DAC=2u L_DAC=5u I_DAC=10u VDC=3.3

.control
  save all
  op
  write lab2.raw
  show all
.endc

**** end user architecture code
**.ends
.end
