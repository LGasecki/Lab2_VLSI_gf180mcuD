* Extracted by KLayout with GF180MCU LVS runset on : 11/09/2026 10:42

.SUBCKT DAC_CORE_5bit DAC_REF I_DAC VDD b[0] b[1] b[2] b[3] b[4]
M$1 VDD DAC_REF VDD VDD pfet_03v3 L=5U W=2U AS=1.3P AD=1.3P PS=5.3U PD=5.3U
M$2 VDD DAC_REF VDD VDD pfet_03v3 L=5U W=2U AS=1.3P AD=1.3P PS=5.3U PD=5.3U
M$3 VDD DAC_REF VDD VDD pfet_03v3 L=5U W=2U AS=1.3P AD=1.3P PS=5.3U PD=5.3U
M$4 VDD DAC_REF VDD VDD pfet_03v3 L=5U W=2U AS=1.3P AD=1.3P PS=5.3U PD=5.3U
M$5 VDD DAC_REF VDD VDD pfet_03v3 L=5U W=2U AS=1.3P AD=1.3P PS=5.3U PD=5.3U
M$6 VDD DAC_REF VDD VDD pfet_03v3 L=5U W=2U AS=1.3P AD=1.3P PS=5.3U PD=5.3U
M$7 VDD DAC_REF VDD VDD pfet_03v3 L=5U W=2U AS=1.3P AD=1.3P PS=5.3U PD=5.3U
M$8 VDD DAC_REF VDD VDD pfet_03v3 L=5U W=2U AS=1.3P AD=1.3P PS=5.3U PD=5.3U
M$9 VDD DAC_REF VDD VDD pfet_03v3 L=5U W=2U AS=1.3P AD=1.3P PS=5.3U PD=5.3U
M$10 VDD DAC_REF \$26 VDD pfet_03v3 L=5U W=2U AS=1.3P AD=1.3P PS=5.3U PD=5.3U
M$11 VDD DAC_REF \$26 VDD pfet_03v3 L=5U W=2U AS=1.3P AD=1.3P PS=5.3U PD=5.3U
M$12 VDD DAC_REF \$26 VDD pfet_03v3 L=5U W=2U AS=1.3P AD=1.3P PS=5.3U PD=5.3U
M$13 VDD DAC_REF VDD VDD pfet_03v3 L=5U W=2U AS=1.3P AD=1.3P PS=5.3U PD=5.3U
M$14 VDD DAC_REF VDD VDD pfet_03v3 L=5U W=2U AS=1.3P AD=1.3P PS=5.3U PD=5.3U
M$15 VDD DAC_REF VDD VDD pfet_03v3 L=5U W=2U AS=1.3P AD=1.3P PS=5.3U PD=5.3U
M$16 VDD DAC_REF \$26 VDD pfet_03v3 L=5U W=2U AS=1.3P AD=1.3P PS=5.3U PD=5.3U
M$17 VDD DAC_REF \$26 VDD pfet_03v3 L=5U W=2U AS=1.3P AD=1.3P PS=5.3U PD=5.3U
M$18 VDD DAC_REF \$26 VDD pfet_03v3 L=5U W=2U AS=1.3P AD=1.3P PS=5.3U PD=5.3U
M$19 VDD DAC_REF \$26 VDD pfet_03v3 L=5U W=2U AS=1.3P AD=1.3P PS=5.3U PD=5.3U
M$20 VDD DAC_REF \$26 VDD pfet_03v3 L=5U W=2U AS=1.3P AD=1.3P PS=5.3U PD=5.3U
M$21 VDD DAC_REF VDD VDD pfet_03v3 L=5U W=2U AS=1.3P AD=1.3P PS=5.3U PD=5.3U
M$22 VDD DAC_REF VDD VDD pfet_03v3 L=5U W=2U AS=1.3P AD=1.3P PS=5.3U PD=5.3U
M$23 VDD DAC_REF \$10 VDD pfet_03v3 L=5U W=2U AS=1.3P AD=1.3P PS=5.3U PD=5.3U
M$24 VDD DAC_REF \$13 VDD pfet_03v3 L=5U W=2U AS=1.3P AD=1.3P PS=5.3U PD=5.3U
M$25 VDD DAC_REF \$14 VDD pfet_03v3 L=5U W=2U AS=1.3P AD=1.3P PS=5.3U PD=5.3U
M$26 VDD DAC_REF \$13 VDD pfet_03v3 L=5U W=2U AS=1.3P AD=1.3P PS=5.3U PD=5.3U
M$27 VDD DAC_REF \$10 VDD pfet_03v3 L=5U W=2U AS=1.3P AD=1.3P PS=5.3U PD=5.3U
M$28 VDD DAC_REF VDD VDD pfet_03v3 L=5U W=2U AS=1.3P AD=1.3P PS=5.3U PD=5.3U
M$29 VDD DAC_REF VDD VDD pfet_03v3 L=5U W=2U AS=1.3P AD=1.3P PS=5.3U PD=5.3U
M$30 VDD DAC_REF \$10 VDD pfet_03v3 L=5U W=2U AS=1.3P AD=1.3P PS=5.3U PD=5.3U
M$31 VDD DAC_REF \$10 VDD pfet_03v3 L=5U W=2U AS=1.3P AD=1.3P PS=5.3U PD=5.3U
M$32 VDD DAC_REF \$7 VDD pfet_03v3 L=5U W=2U AS=1.3P AD=1.3P PS=5.3U PD=5.3U
M$33 VDD DAC_REF \$10 VDD pfet_03v3 L=5U W=2U AS=1.3P AD=1.3P PS=5.3U PD=5.3U
M$34 VDD DAC_REF \$10 VDD pfet_03v3 L=5U W=2U AS=1.3P AD=1.3P PS=5.3U PD=5.3U
M$35 VDD DAC_REF VDD VDD pfet_03v3 L=5U W=2U AS=1.3P AD=1.3P PS=5.3U PD=5.3U
M$36 VDD DAC_REF VDD VDD pfet_03v3 L=5U W=2U AS=1.3P AD=1.3P PS=5.3U PD=5.3U
M$37 VDD DAC_REF \$10 VDD pfet_03v3 L=5U W=2U AS=1.3P AD=1.3P PS=5.3U PD=5.3U
M$38 VDD DAC_REF \$13 VDD pfet_03v3 L=5U W=2U AS=1.3P AD=1.3P PS=5.3U PD=5.3U
M$39 VDD DAC_REF \$14 VDD pfet_03v3 L=5U W=2U AS=1.3P AD=1.3P PS=5.3U PD=5.3U
M$40 VDD DAC_REF \$13 VDD pfet_03v3 L=5U W=2U AS=1.3P AD=1.3P PS=5.3U PD=5.3U
M$41 VDD DAC_REF \$10 VDD pfet_03v3 L=5U W=2U AS=1.3P AD=1.3P PS=5.3U PD=5.3U
M$42 VDD DAC_REF VDD VDD pfet_03v3 L=5U W=2U AS=1.3P AD=1.3P PS=5.3U PD=5.3U
M$43 VDD DAC_REF VDD VDD pfet_03v3 L=5U W=2U AS=1.3P AD=1.3P PS=5.3U PD=5.3U
M$44 VDD DAC_REF \$26 VDD pfet_03v3 L=5U W=2U AS=1.3P AD=1.3P PS=5.3U PD=5.3U
M$45 VDD DAC_REF \$26 VDD pfet_03v3 L=5U W=2U AS=1.3P AD=1.3P PS=5.3U PD=5.3U
M$46 VDD DAC_REF \$26 VDD pfet_03v3 L=5U W=2U AS=1.3P AD=1.3P PS=5.3U PD=5.3U
M$47 VDD DAC_REF \$26 VDD pfet_03v3 L=5U W=2U AS=1.3P AD=1.3P PS=5.3U PD=5.3U
M$48 VDD DAC_REF \$26 VDD pfet_03v3 L=5U W=2U AS=1.3P AD=1.3P PS=5.3U PD=5.3U
M$49 VDD DAC_REF VDD VDD pfet_03v3 L=5U W=2U AS=1.3P AD=1.3P PS=5.3U PD=5.3U
M$50 VDD DAC_REF VDD VDD pfet_03v3 L=5U W=2U AS=1.3P AD=1.3P PS=5.3U PD=5.3U
M$51 VDD DAC_REF VDD VDD pfet_03v3 L=5U W=2U AS=1.3P AD=1.3P PS=5.3U PD=5.3U
M$52 VDD DAC_REF \$26 VDD pfet_03v3 L=5U W=2U AS=1.3P AD=1.3P PS=5.3U PD=5.3U
M$53 VDD DAC_REF \$26 VDD pfet_03v3 L=5U W=2U AS=1.3P AD=1.3P PS=5.3U PD=5.3U
M$54 VDD DAC_REF \$26 VDD pfet_03v3 L=5U W=2U AS=1.3P AD=1.3P PS=5.3U PD=5.3U
M$55 VDD DAC_REF VDD VDD pfet_03v3 L=5U W=2U AS=1.3P AD=1.3P PS=5.3U PD=5.3U
M$56 VDD DAC_REF VDD VDD pfet_03v3 L=5U W=2U AS=1.3P AD=1.3P PS=5.3U PD=5.3U
M$57 VDD DAC_REF VDD VDD pfet_03v3 L=5U W=2U AS=1.3P AD=1.3P PS=5.3U PD=5.3U
M$58 VDD DAC_REF VDD VDD pfet_03v3 L=5U W=2U AS=1.3P AD=1.3P PS=5.3U PD=5.3U
M$59 VDD DAC_REF VDD VDD pfet_03v3 L=5U W=2U AS=1.3P AD=1.3P PS=5.3U PD=5.3U
M$60 VDD DAC_REF VDD VDD pfet_03v3 L=5U W=2U AS=1.3P AD=1.3P PS=5.3U PD=5.3U
M$61 VDD DAC_REF VDD VDD pfet_03v3 L=5U W=2U AS=1.3P AD=1.3P PS=5.3U PD=5.3U
M$62 VDD DAC_REF VDD VDD pfet_03v3 L=5U W=2U AS=1.3P AD=1.3P PS=5.3U PD=5.3U
M$63 VDD DAC_REF VDD VDD pfet_03v3 L=5U W=2U AS=1.3P AD=1.3P PS=5.3U PD=5.3U
M$64 \$26 b[4] I_DAC VDD pfet_03v3 L=0.28U W=0.78U AS=0.507P AD=0.507P PS=2.86U
+ PD=2.86U
M$65 \$26 b[4] I_DAC VDD pfet_03v3 L=0.28U W=0.78U AS=0.507P AD=0.507P PS=2.86U
+ PD=2.86U
M$66 \$26 b[4] I_DAC VDD pfet_03v3 L=0.28U W=0.78U AS=0.507P AD=0.507P PS=2.86U
+ PD=2.86U
M$67 \$26 b[4] I_DAC VDD pfet_03v3 L=0.28U W=0.78U AS=0.507P AD=0.507P PS=2.86U
+ PD=2.86U
M$68 \$10 b[3] I_DAC VDD pfet_03v3 L=0.28U W=0.78U AS=0.507P AD=0.507P PS=2.86U
+ PD=2.86U
M$69 \$10 b[3] I_DAC VDD pfet_03v3 L=0.28U W=0.78U AS=0.507P AD=0.507P PS=2.86U
+ PD=2.86U
M$70 \$13 b[2] I_DAC VDD pfet_03v3 L=0.28U W=0.78U AS=0.507P AD=0.507P PS=2.86U
+ PD=2.86U
M$71 \$14 b[1] I_DAC VDD pfet_03v3 L=0.28U W=0.78U AS=0.507P AD=0.507P PS=2.86U
+ PD=2.86U
M$72 \$26 b[4] I_DAC VDD pfet_03v3 L=0.28U W=0.78U AS=0.507P AD=0.507P PS=2.86U
+ PD=2.86U
M$73 \$26 b[4] I_DAC VDD pfet_03v3 L=0.28U W=0.78U AS=0.507P AD=0.507P PS=2.86U
+ PD=2.86U
M$74 \$26 b[4] I_DAC VDD pfet_03v3 L=0.28U W=0.78U AS=0.507P AD=0.507P PS=2.86U
+ PD=2.86U
M$75 \$26 b[4] I_DAC VDD pfet_03v3 L=0.28U W=0.78U AS=0.507P AD=0.507P PS=2.86U
+ PD=2.86U
M$76 \$10 b[3] I_DAC VDD pfet_03v3 L=0.28U W=0.78U AS=0.507P AD=0.507P PS=2.86U
+ PD=2.86U
M$77 \$10 b[3] I_DAC VDD pfet_03v3 L=0.28U W=0.78U AS=0.507P AD=0.507P PS=2.86U
+ PD=2.86U
M$78 \$13 b[2] I_DAC VDD pfet_03v3 L=0.28U W=0.78U AS=0.507P AD=0.507P PS=2.86U
+ PD=2.86U
M$79 \$26 b[4] I_DAC VDD pfet_03v3 L=0.28U W=0.78U AS=0.507P AD=0.507P PS=2.86U
+ PD=2.86U
M$80 \$26 b[4] I_DAC VDD pfet_03v3 L=0.28U W=0.78U AS=0.507P AD=0.507P PS=2.86U
+ PD=2.86U
M$81 \$26 b[4] I_DAC VDD pfet_03v3 L=0.28U W=0.78U AS=0.507P AD=0.507P PS=2.86U
+ PD=2.86U
M$82 \$26 b[4] I_DAC VDD pfet_03v3 L=0.28U W=0.78U AS=0.507P AD=0.507P PS=2.86U
+ PD=2.86U
M$83 \$10 b[3] I_DAC VDD pfet_03v3 L=0.28U W=0.78U AS=0.507P AD=0.507P PS=2.86U
+ PD=2.86U
M$84 \$10 b[3] I_DAC VDD pfet_03v3 L=0.28U W=0.78U AS=0.507P AD=0.507P PS=2.86U
+ PD=2.86U
M$85 \$13 b[2] I_DAC VDD pfet_03v3 L=0.28U W=0.78U AS=0.507P AD=0.507P PS=2.86U
+ PD=2.86U
M$86 \$14 b[1] I_DAC VDD pfet_03v3 L=0.28U W=0.78U AS=0.507P AD=0.507P PS=2.86U
+ PD=2.86U
M$87 I_DAC b[1] I_DAC VDD pfet_03v3 L=0.28U W=0.78U AS=0.507P AD=0.507P
+ PS=2.86U PD=2.86U
M$88 \$26 b[4] I_DAC VDD pfet_03v3 L=0.28U W=0.78U AS=0.507P AD=0.507P PS=2.86U
+ PD=2.86U
M$89 \$26 b[4] I_DAC VDD pfet_03v3 L=0.28U W=0.78U AS=0.507P AD=0.507P PS=2.86U
+ PD=2.86U
M$90 \$26 b[4] I_DAC VDD pfet_03v3 L=0.28U W=0.78U AS=0.507P AD=0.507P PS=2.86U
+ PD=2.86U
M$91 \$26 b[4] I_DAC VDD pfet_03v3 L=0.28U W=0.78U AS=0.507P AD=0.507P PS=2.86U
+ PD=2.86U
M$92 \$10 b[3] I_DAC VDD pfet_03v3 L=0.28U W=0.78U AS=0.507P AD=0.507P PS=2.86U
+ PD=2.86U
M$93 \$10 b[3] I_DAC VDD pfet_03v3 L=0.28U W=0.78U AS=0.507P AD=0.507P PS=2.86U
+ PD=2.86U
M$94 \$13 b[2] I_DAC VDD pfet_03v3 L=0.28U W=0.78U AS=0.507P AD=0.507P PS=2.86U
+ PD=2.86U
M$95 \$7 b[0] I_DAC VDD pfet_03v3 L=0.28U W=0.78U AS=0.507P AD=0.507P PS=2.86U
+ PD=2.86U
.ENDS DAC_CORE_5bit
