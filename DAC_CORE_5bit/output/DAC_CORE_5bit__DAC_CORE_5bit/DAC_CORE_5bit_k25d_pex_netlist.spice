*********************************************************
*** NGSPICE file created by KLayout-PEX 0.3.12
*** -----------------------------------------------------
***     Extraction Engine: KPEX/2.5D
***     Technology: gf180mcud
***     Date: 2026-09-11 10:42:10
*********************************************************

.SUBCKT DAC_CORE_5bit DAC_REF I_DAC VDD b[0] b[1] b[2] b[3] b[4]
M$1 VDD DAC_REF VDD VDD pfet_03v3 L=5U W=2U AS=1.3P AD=1.3P PS=5.3U PD=5.3U
M$2 VDD DAC_REF VDD VDD pfet_03v3 L=5U W=2U AS=1.3P AD=1.3P PS=5.3U PD=5.3U
M$3 VDD DAC_REF VDD VDD pfet_03v3 L=5U W=2U AS=1.3P AD=1.3P PS=5.3U PD=5.3U
M$4 VDD DAC_REF VDD VDD pfet_03v3 L=5U W=2U AS=1.3P AD=1.3P PS=5.3U PD=5.3U
M$5 VDD DAC_REF VDD VDD pfet_03v3 L=5U W=2U AS=1.3P AD=1.3P PS=5.3U PD=5.3U
M$6 VDD DAC_REF VDD VDD pfet_03v3 L=5U W=2U AS=1.3P AD=1.3P PS=5.3U PD=5.3U
M$7 VDD DAC_REF VDD VDD pfet_03v3 L=5U W=2U AS=1.3P AD=1.3P PS=5.3U PD=5.3U
M$8 VDD DAC_REF VDD VDD pfet_03v3 L=5U W=2U AS=1.3P AD=1.3P PS=5.3U PD=5.3U
M$9 VDD DAC_REF VDD VDD pfet_03v3 L=5U W=2U AS=1.3P AD=1.3P PS=5.3U PD=5.3U
M$10 VDD DAC_REF \$26 VDD pfet_03v3 L=5U W=2U AS=1.3P AD=1.3P PS=5.3U PD=5.3U
M$11 VDD DAC_REF \$26 VDD pfet_03v3 L=5U W=2U AS=1.3P AD=1.3P PS=5.3U PD=5.3U
M$12 VDD DAC_REF \$26 VDD pfet_03v3 L=5U W=2U AS=1.3P AD=1.3P PS=5.3U PD=5.3U
M$13 VDD DAC_REF VDD VDD pfet_03v3 L=5U W=2U AS=1.3P AD=1.3P PS=5.3U PD=5.3U
M$14 VDD DAC_REF VDD VDD pfet_03v3 L=5U W=2U AS=1.3P AD=1.3P PS=5.3U PD=5.3U
M$15 VDD DAC_REF VDD VDD pfet_03v3 L=5U W=2U AS=1.3P AD=1.3P PS=5.3U PD=5.3U
M$16 VDD DAC_REF \$26 VDD pfet_03v3 L=5U W=2U AS=1.3P AD=1.3P PS=5.3U PD=5.3U
M$17 VDD DAC_REF \$26 VDD pfet_03v3 L=5U W=2U AS=1.3P AD=1.3P PS=5.3U PD=5.3U
M$18 VDD DAC_REF \$26 VDD pfet_03v3 L=5U W=2U AS=1.3P AD=1.3P PS=5.3U PD=5.3U
M$19 VDD DAC_REF \$26 VDD pfet_03v3 L=5U W=2U AS=1.3P AD=1.3P PS=5.3U PD=5.3U
M$20 VDD DAC_REF \$26 VDD pfet_03v3 L=5U W=2U AS=1.3P AD=1.3P PS=5.3U PD=5.3U
M$21 VDD DAC_REF VDD VDD pfet_03v3 L=5U W=2U AS=1.3P AD=1.3P PS=5.3U PD=5.3U
M$22 VDD DAC_REF VDD VDD pfet_03v3 L=5U W=2U AS=1.3P AD=1.3P PS=5.3U PD=5.3U
M$23 VDD DAC_REF \$10 VDD pfet_03v3 L=5U W=2U AS=1.3P AD=1.3P PS=5.3U PD=5.3U
M$24 VDD DAC_REF \$13 VDD pfet_03v3 L=5U W=2U AS=1.3P AD=1.3P PS=5.3U PD=5.3U
M$25 VDD DAC_REF \$14 VDD pfet_03v3 L=5U W=2U AS=1.3P AD=1.3P PS=5.3U PD=5.3U
M$26 VDD DAC_REF \$13 VDD pfet_03v3 L=5U W=2U AS=1.3P AD=1.3P PS=5.3U PD=5.3U
M$27 VDD DAC_REF \$10 VDD pfet_03v3 L=5U W=2U AS=1.3P AD=1.3P PS=5.3U PD=5.3U
M$28 VDD DAC_REF VDD VDD pfet_03v3 L=5U W=2U AS=1.3P AD=1.3P PS=5.3U PD=5.3U
M$29 VDD DAC_REF VDD VDD pfet_03v3 L=5U W=2U AS=1.3P AD=1.3P PS=5.3U PD=5.3U
M$30 VDD DAC_REF \$10 VDD pfet_03v3 L=5U W=2U AS=1.3P AD=1.3P PS=5.3U PD=5.3U
M$31 VDD DAC_REF \$10 VDD pfet_03v3 L=5U W=2U AS=1.3P AD=1.3P PS=5.3U PD=5.3U
M$32 VDD DAC_REF \$7 VDD pfet_03v3 L=5U W=2U AS=1.3P AD=1.3P PS=5.3U PD=5.3U
M$33 VDD DAC_REF \$10 VDD pfet_03v3 L=5U W=2U AS=1.3P AD=1.3P PS=5.3U PD=5.3U
M$34 VDD DAC_REF \$10 VDD pfet_03v3 L=5U W=2U AS=1.3P AD=1.3P PS=5.3U PD=5.3U
M$35 VDD DAC_REF VDD VDD pfet_03v3 L=5U W=2U AS=1.3P AD=1.3P PS=5.3U PD=5.3U
M$36 VDD DAC_REF VDD VDD pfet_03v3 L=5U W=2U AS=1.3P AD=1.3P PS=5.3U PD=5.3U
M$37 VDD DAC_REF \$10 VDD pfet_03v3 L=5U W=2U AS=1.3P AD=1.3P PS=5.3U PD=5.3U
M$38 VDD DAC_REF \$13 VDD pfet_03v3 L=5U W=2U AS=1.3P AD=1.3P PS=5.3U PD=5.3U
M$39 VDD DAC_REF \$14 VDD pfet_03v3 L=5U W=2U AS=1.3P AD=1.3P PS=5.3U PD=5.3U
M$40 VDD DAC_REF \$13 VDD pfet_03v3 L=5U W=2U AS=1.3P AD=1.3P PS=5.3U PD=5.3U
M$41 VDD DAC_REF \$10 VDD pfet_03v3 L=5U W=2U AS=1.3P AD=1.3P PS=5.3U PD=5.3U
M$42 VDD DAC_REF VDD VDD pfet_03v3 L=5U W=2U AS=1.3P AD=1.3P PS=5.3U PD=5.3U
M$43 VDD DAC_REF VDD VDD pfet_03v3 L=5U W=2U AS=1.3P AD=1.3P PS=5.3U PD=5.3U
M$44 VDD DAC_REF \$26 VDD pfet_03v3 L=5U W=2U AS=1.3P AD=1.3P PS=5.3U PD=5.3U
M$45 VDD DAC_REF \$26 VDD pfet_03v3 L=5U W=2U AS=1.3P AD=1.3P PS=5.3U PD=5.3U
M$46 VDD DAC_REF \$26 VDD pfet_03v3 L=5U W=2U AS=1.3P AD=1.3P PS=5.3U PD=5.3U
M$47 VDD DAC_REF \$26 VDD pfet_03v3 L=5U W=2U AS=1.3P AD=1.3P PS=5.3U PD=5.3U
M$48 VDD DAC_REF \$26 VDD pfet_03v3 L=5U W=2U AS=1.3P AD=1.3P PS=5.3U PD=5.3U
M$49 VDD DAC_REF VDD VDD pfet_03v3 L=5U W=2U AS=1.3P AD=1.3P PS=5.3U PD=5.3U
M$50 VDD DAC_REF VDD VDD pfet_03v3 L=5U W=2U AS=1.3P AD=1.3P PS=5.3U PD=5.3U
M$51 VDD DAC_REF VDD VDD pfet_03v3 L=5U W=2U AS=1.3P AD=1.3P PS=5.3U PD=5.3U
M$52 VDD DAC_REF \$26 VDD pfet_03v3 L=5U W=2U AS=1.3P AD=1.3P PS=5.3U PD=5.3U
M$53 VDD DAC_REF \$26 VDD pfet_03v3 L=5U W=2U AS=1.3P AD=1.3P PS=5.3U PD=5.3U
M$54 VDD DAC_REF \$26 VDD pfet_03v3 L=5U W=2U AS=1.3P AD=1.3P PS=5.3U PD=5.3U
M$55 VDD DAC_REF VDD VDD pfet_03v3 L=5U W=2U AS=1.3P AD=1.3P PS=5.3U PD=5.3U
M$56 VDD DAC_REF VDD VDD pfet_03v3 L=5U W=2U AS=1.3P AD=1.3P PS=5.3U PD=5.3U
M$57 VDD DAC_REF VDD VDD pfet_03v3 L=5U W=2U AS=1.3P AD=1.3P PS=5.3U PD=5.3U
M$58 VDD DAC_REF VDD VDD pfet_03v3 L=5U W=2U AS=1.3P AD=1.3P PS=5.3U PD=5.3U
M$59 VDD DAC_REF VDD VDD pfet_03v3 L=5U W=2U AS=1.3P AD=1.3P PS=5.3U PD=5.3U
M$60 VDD DAC_REF VDD VDD pfet_03v3 L=5U W=2U AS=1.3P AD=1.3P PS=5.3U PD=5.3U
M$61 VDD DAC_REF VDD VDD pfet_03v3 L=5U W=2U AS=1.3P AD=1.3P PS=5.3U PD=5.3U
M$62 VDD DAC_REF VDD VDD pfet_03v3 L=5U W=2U AS=1.3P AD=1.3P PS=5.3U PD=5.3U
M$63 VDD DAC_REF VDD VDD pfet_03v3 L=5U W=2U AS=1.3P AD=1.3P PS=5.3U PD=5.3U
M$64 \$26 b[4] I_DAC VDD pfet_03v3 L=0.28U W=0.78U AS=0.507P AD=0.507P PS=2.86U
+ PD=2.86U
M$65 \$26 b[4] I_DAC VDD pfet_03v3 L=0.28U W=0.78U AS=0.507P AD=0.507P PS=2.86U
+ PD=2.86U
M$66 \$26 b[4] I_DAC VDD pfet_03v3 L=0.28U W=0.78U AS=0.507P AD=0.507P PS=2.86U
+ PD=2.86U
M$67 \$26 b[4] I_DAC VDD pfet_03v3 L=0.28U W=0.78U AS=0.507P AD=0.507P PS=2.86U
+ PD=2.86U
M$68 \$10 b[3] I_DAC VDD pfet_03v3 L=0.28U W=0.78U AS=0.507P AD=0.507P PS=2.86U
+ PD=2.86U
M$69 \$10 b[3] I_DAC VDD pfet_03v3 L=0.28U W=0.78U AS=0.507P AD=0.507P PS=2.86U
+ PD=2.86U
M$70 \$13 b[2] I_DAC VDD pfet_03v3 L=0.28U W=0.78U AS=0.507P AD=0.507P PS=2.86U
+ PD=2.86U
M$71 \$14 b[1] I_DAC VDD pfet_03v3 L=0.28U W=0.78U AS=0.507P AD=0.507P PS=2.86U
+ PD=2.86U
M$72 \$26 b[4] I_DAC VDD pfet_03v3 L=0.28U W=0.78U AS=0.507P AD=0.507P PS=2.86U
+ PD=2.86U
M$73 \$26 b[4] I_DAC VDD pfet_03v3 L=0.28U W=0.78U AS=0.507P AD=0.507P PS=2.86U
+ PD=2.86U
M$74 \$26 b[4] I_DAC VDD pfet_03v3 L=0.28U W=0.78U AS=0.507P AD=0.507P PS=2.86U
+ PD=2.86U
M$75 \$26 b[4] I_DAC VDD pfet_03v3 L=0.28U W=0.78U AS=0.507P AD=0.507P PS=2.86U
+ PD=2.86U
M$76 \$10 b[3] I_DAC VDD pfet_03v3 L=0.28U W=0.78U AS=0.507P AD=0.507P PS=2.86U
+ PD=2.86U
M$77 \$10 b[3] I_DAC VDD pfet_03v3 L=0.28U W=0.78U AS=0.507P AD=0.507P PS=2.86U
+ PD=2.86U
M$78 \$13 b[2] I_DAC VDD pfet_03v3 L=0.28U W=0.78U AS=0.507P AD=0.507P PS=2.86U
+ PD=2.86U
M$79 \$26 b[4] I_DAC VDD pfet_03v3 L=0.28U W=0.78U AS=0.507P AD=0.507P PS=2.86U
+ PD=2.86U
M$80 \$26 b[4] I_DAC VDD pfet_03v3 L=0.28U W=0.78U AS=0.507P AD=0.507P PS=2.86U
+ PD=2.86U
M$81 \$26 b[4] I_DAC VDD pfet_03v3 L=0.28U W=0.78U AS=0.507P AD=0.507P PS=2.86U
+ PD=2.86U
M$82 \$26 b[4] I_DAC VDD pfet_03v3 L=0.28U W=0.78U AS=0.507P AD=0.507P PS=2.86U
+ PD=2.86U
M$83 \$10 b[3] I_DAC VDD pfet_03v3 L=0.28U W=0.78U AS=0.507P AD=0.507P PS=2.86U
+ PD=2.86U
M$84 \$10 b[3] I_DAC VDD pfet_03v3 L=0.28U W=0.78U AS=0.507P AD=0.507P PS=2.86U
+ PD=2.86U
M$85 \$13 b[2] I_DAC VDD pfet_03v3 L=0.28U W=0.78U AS=0.507P AD=0.507P PS=2.86U
+ PD=2.86U
M$86 \$14 b[1] I_DAC VDD pfet_03v3 L=0.28U W=0.78U AS=0.507P AD=0.507P PS=2.86U
+ PD=2.86U
M$87 I_DAC b[1] I_DAC VDD pfet_03v3 L=0.28U W=0.78U AS=0.507P AD=0.507P
+ PS=2.86U PD=2.86U
M$88 \$26 b[4] I_DAC VDD pfet_03v3 L=0.28U W=0.78U AS=0.507P AD=0.507P PS=2.86U
+ PD=2.86U
M$89 \$26 b[4] I_DAC VDD pfet_03v3 L=0.28U W=0.78U AS=0.507P AD=0.507P PS=2.86U
+ PD=2.86U
M$90 \$26 b[4] I_DAC VDD pfet_03v3 L=0.28U W=0.78U AS=0.507P AD=0.507P PS=2.86U
+ PD=2.86U
M$91 \$26 b[4] I_DAC VDD pfet_03v3 L=0.28U W=0.78U AS=0.507P AD=0.507P PS=2.86U
+ PD=2.86U
M$92 \$10 b[3] I_DAC VDD pfet_03v3 L=0.28U W=0.78U AS=0.507P AD=0.507P PS=2.86U
+ PD=2.86U
M$93 \$10 b[3] I_DAC VDD pfet_03v3 L=0.28U W=0.78U AS=0.507P AD=0.507P PS=2.86U
+ PD=2.86U
M$94 \$13 b[2] I_DAC VDD pfet_03v3 L=0.28U W=0.78U AS=0.507P AD=0.507P PS=2.86U
+ PD=2.86U
M$95 \$7 b[0] I_DAC VDD pfet_03v3 L=0.28U W=0.78U AS=0.507P AD=0.507P PS=2.86U
+ PD=2.86U
Cext_1 \$10 \$13 1.66034f
Cext_2 \$10 \$14 258.32a
Cext_3 \$10 \$26 3.26096f
Cext_4 \$10 \$7 697.986a
Cext_5 \$10 b[0] 3.2091a
Cext_6 \$10 b[2] 439.25a
Cext_7 \$10 b[3] 2.10532f
Cext_8 \$10 b[4] 12.4248a
Cext_9 \$10 DAC_REF 12.1781a
Cext_10 \$10 I_DAC 806.71a
Cext_11 \$10 VDD 9.02589f
Cext_12 \$10 VSUBS 6.45286f
Cext_13 \$13 \$14 2.93437f
Cext_14 \$13 \$26 487.117a
Cext_15 \$13 \$7 96.5756a
Cext_16 \$13 b[0] 117.002a
Cext_17 \$13 b[1] 326.378a
Cext_18 \$13 b[2] 524.878a
Cext_19 \$13 I_DAC 361.196a
Cext_20 \$13 VDD 4.69446f
Cext_21 \$13 VSUBS 2.89705f
Cext_22 \$14 \$26 349.449a
Cext_23 \$14 \$7 1.17793f
Cext_24 \$14 b[0] 140.154a
Cext_25 \$14 b[1] 126.037a
Cext_26 \$14 I_DAC 329.338a
Cext_27 \$14 VDD 2.66778f
Cext_28 \$14 VSUBS 1.55931f
Cext_29 \$26 \$7 329.125a
Cext_30 \$26 b[3] 73.2627a
Cext_31 \$26 b[4] 3.88715f
Cext_32 \$26 DAC_REF 153.585a
Cext_33 \$26 I_DAC 1.32585f
Cext_34 \$26 VDD 11.6327f
Cext_35 \$26 VSUBS 9.17868f
Cext_36 \$7 b[0] 298.612a
Cext_37 \$7 I_DAC 53.9456a
Cext_38 \$7 VDD 1.70063f
Cext_39 \$7 VSUBS 1.42995f
Cext_40 b[0] b[1] 50.2269a
Cext_41 b[0] b[2] 15.7368a
Cext_42 b[1] b[2] 62.0816a
Cext_43 b[1] b[3] 0.0955942a
Cext_44 b[2] b[3] 79.258a
Cext_45 b[3] b[4] 252.367a
Cext_46 DAC_REF VDD 2.64357f
Cext_47 DAC_REF VSUBS 962.298a
Cext_48 I_DAC b[0] 1.1527f
Cext_49 I_DAC b[1] 659.926a
Cext_50 I_DAC b[2] 794.468a
Cext_51 I_DAC b[3] 1.62478f
Cext_52 I_DAC b[4] 3.57146f
Cext_53 I_DAC VDD 1.18664f
Cext_54 I_DAC VSUBS 3.64714f
Cext_55 VDD b[0] 2.27279f
Cext_56 VDD b[1] 110.483a
Cext_57 VDD b[2] 136.555a
Cext_58 VDD b[3] 227.556a
Cext_59 VDD b[4] 779.211a
Cext_60 VDD VSUBS 55.3136f
Cext_61 VSUBS b[0] 693.207a
Cext_62 VSUBS b[1] 413.14a
Cext_63 VSUBS b[2] 449.849a
Cext_64 VSUBS b[3] 952.246a
Cext_65 VSUBS b[4] 2.06308f
.ENDS DAC_CORE_5bit
